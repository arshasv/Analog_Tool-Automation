* NGSPICE file created from smart_vco_optimized.ext - technology: sky130A

.subckt smart_vco_optimized
X0 a_0_415# w 7.014692688900876 l 1.4927256544996241.B w 1.6915750971810644 l 1.4927256544996241.B sky130_fd_pr__cap_var_lvt w=0.085 l=0.395
X1 w 1.6915750971810644 l 1.4927256544996241.D a_17_17# w 1.6915750971810644 l 1.4927256544996241.D w 1.6915750971810644 l 1.4927256544996241.B sky130_fd_pr__nfet_01v8 ad=0.0474 pd=0.65 as=0.0948 ps=1.3 w=0.45 l=0.06
X2 w 1.6915750971810644 l 1.4927256544996241.S w 1.6915750971810644 l 1.4927256544996241.G w 1.6915750971810644 l 1.4927256544996241.D w 1.6915750971810644 l 1.4927256544996241.B sky130_fd_pr__nfet_01v8 ad=0.1218 pd=1.42 as=0.0474 ps=0.65 w=0.42 l=0.15
X3 w 7.014692688900876 l 1.4927256544996241.S w 7.014692688900876 l 1.4927256544996241.G w 7.014692688900876 l 1.4927256544996241.D w 7.014692688900876 l 1.4927256544996241.B sky130_fd_pr__pfet_01v8 ad=0.1218 pd=1.42 as=0.1218 ps=1.42 w=0.42 l=0.15
.ends
