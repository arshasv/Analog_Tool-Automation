* Generated netlist for proc_deb0e0dcd148
* Source: data/designs/uploads/proc_deb0e0dcd148_test_circuit.py
.include /opt/open_pdks/sky130/sky130A/libs.tech/ngspice/sky130.lib.spice
* Parameters:
* iref = 1e-05
* vdd = 1.8
.op
.end
