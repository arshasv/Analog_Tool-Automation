* Generated netlist for proc_3bcfc26adcd9
* Source: data/designs/uploads/proc_3bcfc26adcd9_circuit.py
.include /opt/open_pdks/sky130/sky130A/libs.tech/ngspice/sky130.lib.spice
* Parameters:
* iref = 2e-05
* length = 1.0
.op
.end
