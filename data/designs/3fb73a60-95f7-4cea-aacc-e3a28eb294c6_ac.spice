* Parametric AC Analysis for 3fb73a60-95f7-4cea-aacc-e3a28eb294c6_current_mirror
.options compat=ps
.options reltol=1e-3 gmin=1e-12 scale=1u
.lib "/opt/sky130_pdk/sky130A/libs.tech/ngspice/sky130.lib.spice" tt
.temp 27

* Sky130 DRC Safe Clamps
.func clampW(x) = {max(0.42u, min(x, 50u))}
.func clampL(x) = {max(0.15u, min(x, 5u))}

* Computed Parameters
.param length = {clampL(0.5)}
.param width = {clampW(2)}

* Circuit Implementation
* Simple Current Mirror Test Circuit
* Generator: current_mirror.py
* @AC_SOURCE: Iref
* @AC_EXPR: i(vmeas)
* @TRAN_EXPR: i(vmeas)
* @DC_EXPR: i(vmeas)

* Parameters
.param w = 2u
.param l = 0.5u

* Supply
Vdd vdd 0 1.8

* Reference current (DC + AC excitation + Pulse for TRAN)
Iref vdd d_ref pulse(80u 120u 1u 1n 1n 5u 10u) ac 1

* Circuit — Current Mirror
XM1 d_ref d_ref 0 0 sky130_fd_pr__nfet_01v8 w={w} l={l}
XM2 vout d_ref 0 0 sky130_fd_pr__nfet_01v8 w={w} l={l}

* Output load with current measurement
Vmeas v_load_pin vout 0
Rload vdd v_load_pin 10k
Cout vout 0 1p

* Analysis

* AC Analysis
.ac dec 50 100 100000000
.control
set ngbehavior=hs
run
set filetype=ascii
wrdata 3fb73a60-95f7-4cea-aacc-e3a28eb294c6_ac.csv i(vmeas)
.endc
.end
