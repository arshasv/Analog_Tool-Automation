* Generated netlist for proc_c4f4e6c5e4e9
* Source: data/designs/uploads/proc_c4f4e6c5e4e9_circuit.py
.include /opt/open_pdks/sky130/sky130A/libs.tech/ngspice/sky130.lib.spice
* Parameters:
* width = 2.0
* length = 0.5
.op
.end
