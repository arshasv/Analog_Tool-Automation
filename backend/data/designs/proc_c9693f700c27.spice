* Generated netlist for proc_c9693f700c27
* Source: data/designs/uploads/proc_c9693f700c27_sky130_current_mirror.py
.include /opt/open_pdks/sky130/sky130A/libs.tech/ngspice/sky130.lib.spice
* Parameters:
.op
.end
