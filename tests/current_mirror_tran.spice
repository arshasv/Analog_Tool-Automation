* Sky130 Current Mirror - Transient Analysis (FINAL FIXED)

* ==== Required for Sky130 ====
.option scale=1u
.option ngbehavior=hs
.option reltol=1e-3
.option gmin=1e-12

.temp 27

* ==== Load Sky130 TT Corner ====
.lib /usr/local/share/pdk/sky130A/libs.tech/ngspice/sky130.lib.spice tt

* ==== Parameters (microns because scale=1u) ====
.param W = 2
.param L = 0.5

* ==== Supply ====
Vdd vdd 0 1.8

* ==== Reference Current (Pulse for transient test) ====
* 80uA -> 120uA step at 1us
Iref vdd d_ref PULSE(80u 120u 1u 1n 1n 5u 10u)

* ==== Current Mirror ====
XM1 d_ref d_ref 0 0 sky130_fd_pr__nfet_01v8 W={W} L={L}
XM2 vout d_ref 0 0 sky130_fd_pr__nfet_01v8 W={W} L={L}

* ==== Output Load ====
Vmeas vout vload 0
Rload vdd vload 10k
Cout vout 0 1p

* ==== Transient Analysis ====
.tran 1n 30u

.control
set ngbehavior=hs
run
plot i(Vmeas)
wrdata tran_results.csv time i(Vmeas)
.endc

.end
