* Sky130 Current Mirror - AC Analysis (FINAL FIXED)

* ==== Required for Sky130 Models ====
.option scale=1u
.option gmin=1e-12
.option reltol=1e-3
.option ngbehavior=hs

* ==== Load Sky130 TT Corner ====
.lib /usr/local/share/pdk/sky130A/libs.tech/ngspice/sky130.lib.spice tt

* ==== Parameters ====
.param W = 2
.param L = 0.5

* ==== Supply ====
Vdd vdd 0 1.8

* ==== Reference Current ====
Iref vdd d_ref DC 100u AC 1

* ==== Current Mirror ====
XM1 d_ref d_ref 0 0 sky130_fd_pr__nfet_01v8 W={W} L={L}
XM2 vout d_ref 0 0 sky130_fd_pr__nfet_01v8 W={W} L={L}

* ==== Output Load ====
Vmeas vout vload 0
Rload vdd vload 10k

* ==== AC Analysis ====
.ac dec 50 100 100MEG

.control
set ngbehavior=hs
run
plot db(i(Vmeas))
.endc

.end
